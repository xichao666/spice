** Profile: "SCHEMATIC1-bias"  [ C:\Users\Archit\Desktop\PSPICE Simulations\Schmitt circuit 1\using netlist\schmitt circuit 1-schematic1-bias.sim ]

** Creating circuit file "schmitt circuit 1-schematic1-bias.sim.cir"
** WARNING: THIS AUTOMATICALLY GENERATED FILE MAY BE OVERWRITTEN BY SUBSEQUENT SIMULATIONS

*Libraries:
* Local Libraries :
* From [PSPICE NETLIST] section of C:\Program Files\OrcadLite\PSpice\PSpice.ini file:
.lib "nom.lib"

*Analysis directives:
.TEMP 26
.PROBE V(*) I(*) W(*) D(*) NOISE(*)
.INC ".\schmitt circuit 1-SCHEMATIC1.net"

.END
